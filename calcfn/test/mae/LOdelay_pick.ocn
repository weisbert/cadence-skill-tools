; LOdelay_pick.ocn -- the form's "Select" buttons against calcfn_tb/LOdelay/schematic
; (run LOdelay_mae.ocn once first; run with ../run_gui.sh from this directory).
load("../../calcfn.il")
LDP_fail = 0
procedure( LDP_chk(name got want)
  if(got == want
    then printf("CASE PASS %-34s got=%L\n" name got)
    else LDP_fail++ printf("CASE FAIL %-34s got=%L want=%L\n" name got want)))
; middle of the wire of net `name` (its ends sit on instance pins)
procedure( LDP_wirePt(cv name)
  let((pts) pts = car(setof(x cv~>shapes x~>net && x~>net~>name == name && x~>points))~>points
    list((xCoord(car(pts)) + xCoord(cadr(pts)))/2.0 (yCoord(car(pts)) + yCoord(cadr(pts)))/2.0)))

LDP_win = geOpen(?lib "calcfn_tb" ?cell "LOdelay" ?view "schematic" ?mode "r")
LDP_cv = geGetEditCellView(LDP_win)
calCalculatorFormCB()
LOdelay_specialCB()
LDP_f = LOdelay_form()

; 1. something already selected -> taken at once, then deselected
geSelectFig(car(setof(x LDP_cv~>shapes x~>net && x~>net~>name == "buf")))
LOdelay_pick('outNet "out")
LDP_chk("selected wire -> Out field" LDP_f->outNet->value "/buf")
LDP_chk("selection cleared" geGetSelSet(LDP_win) nil)
; 2. a click on a wire (what enterPoint hands the done proc)
LOdelay_pickField = 'refNet
LOdelay_pickDone(LDP_win t list(LDP_wirePt(LDP_cv "inv")))
LDP_chk("click on wire -> Ref field" LDP_f->refNet->value "/inv")
; 3. a click on empty space leaves the field alone
LOdelay_pickDone(LDP_win t list(list(-20.0 -20.0)))
LDP_chk("click on nothing -> unchanged" LDP_f->refNet->value "/inv")
; 4. nothing selected -> interactive pick starts in the schematic window
LOdelay_pick('refNet "ref")
procedure( LDP_after()
  LDP_chk("interactive pick started" hiGetCurrentCmd(LDP_win) "LOdelay Select")
  printf("SUMMARY pick fail=%d\n" LDP_fail)
  exit())
hiRegTimer("LDP_after()" 20)   ; the pick is launched from a timer, like a real button press
