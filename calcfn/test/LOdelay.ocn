; LOdelay.ocn -- acceptance cases for LOdelay against tb.scs (answers known by construction)
load("../calcfn.il")
openResults("./psf")
selectResult('tran)
nPass = 0  nFail = 0
procedure( chk(name got want)
  if( (and numberp(got) numberp(want) abs(got - want) < 0.1e-12)
         || (got == want)
    then nPass++ printf("CASE PASS %-28s got=%L\n" name got)
    else nFail++ printf("CASE FAIL %-28s got=%L want=%L\n" name got want)))
in = v("in")
chk("buf rise->rise"        LOdelay(in v("buf"))                          0.35e-9)
naive = cross(clip(v("buf") 0.3n 9.9n) 0.5 1 'rising) - cross(clip(in 0.3n 9.9n) 0.5 1 'rising)
chk("naive clipped = Td-T"  naive                                         -0.65e-9)
chk("clipped both"          LOdelay(clip(in 0.3n 9.9n) clip(v("buf") 0.3n 9.9n)) 0.35e-9)
chk("?from 0.3n"            LOdelay(in v("buf") ?from 0.3n)               0.35e-9)
chk("?from ?to count"       LOdelay(in v("buf") ?from 2n ?to 5n ?stat "count") 3)
chk("inv rise->fall"        LOdelay(in v("inv") ?outEdge "falling")       0.30e-9)
chk("either->either"        LOdelay(in v("buf") ?refEdge "either" ?outEdge "either") 0.35e-9)
chk("div2"                  LOdelay(in v("div2"))                         0.12e-9)
chk("div2slow no tmin (alias)" LOdelay(in v("div2slow"))                  0.08e-9)
chk("div2slow ?tmin 0.5n"   LOdelay(in v("div2slow") ?tmin 0.5n)          1.08e-9)
chk("rstn first"            LOdelay(v("rstn") v("ckg") ?stat "first")     0.47e-9)
chk("diff thr 0"            LOdelay(v("inp")-v("inn") v("outp")-v("outn") ?refThr 0 ?outThr 0) 0.20e-9)
chk("CML auto threshold"    LOdelay(in v("outp"))                         0.20e-9)
chk("count"                 LOdelay(in v("buf") ?stat "count")            10)
chk("skip 2 count"          LOdelay(in v("buf") ?skip 2 ?stat "count")    8)
chk("std ~ 0"               LOdelay(in v("buf") ?stat "std")              0.0)
chk("pp ~ 0"                LOdelay(in v("buf") ?stat "pp")               0.0)
chk("min"                   LOdelay(in v("buf") ?stat "min")              0.35e-9)
chk("last"                  LOdelay(in v("buf") ?stat "last")             0.35e-9)
w = LOdelay(in v("buf") ?stat "wave")
chk("wave is waveform"      drIsWaveform(w)                               t)
chk("wave first y"          drGetElem(drGetWaveformYVec(w) 0)             0.35e-9)
chk("wave first x"          drGetElem(drGetWaveformXVec(w) 0)             0.46e-9)
chk("bad stat -> error"     car(errset(LOdelay(in v("buf") ?stat "avg")))  nil)
chk("no pairs -> nil"       LOdelay(v("ckg") v("rstn"))                   nil)
chk("spike, no window -> nil" LOdelay(in v("bufspk"))                       nil)
chk("spike, ?from 0.3n"     LOdelay(in v("bufspk") ?from 0.3n)            0.35e-9)
printf("SUMMARY pass=%d fail=%d\n" nPass nFail)
exit()
