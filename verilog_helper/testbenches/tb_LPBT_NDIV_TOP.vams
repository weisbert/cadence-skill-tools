`timescale 1ps/1fs
// -----------------------------------------------------------------------------
// tb_LPBT_NDIV_TOP.vams -- real testbench for the LPBT_NDIV_TOP feedback divider.
//
// Strategy = "period-ratio" check: drive fromVCO as a square clock, set the divide
// word + the live enables (lpbt_en NC), and for each MODE measure
// period(out)/period(fromVCO) and assert the expected divide, plus assert the
// outputs which should be quiet in that mode have no edges, plus assert OUT_NDIV's
// duty cycle.
//
// MODE behaviors are CONFIRMED FROM THE STAGE-A NETLIST (clock tree traced 2026-06-26):
//   front-end : fromVCO -div2(I7)- -div2(I9)- DIV4sig = VCO/4   (the /4 prescaler)
//   CAL  cal_en=1 : CLK2CNT=nand(DIV4sig,cal_en)=VCO/4 ; NDIVCKIN=nor(DIV4sig,cal_en)
//                   frozen -> OUT_NDIV/CLK2DSM quiet ; TESTCLK pulled low (en_test=0)
//   TEST en_test=1: DIV4sig -div4_tspc- = VCO/16 -> TESTCLK_300M ; CLK2CNT static-high
//                   OUT_NDIV=CLK2DSM=VCO/4/(ndiv-1) (divider runs, cal_en=0)
//   NORM cal_en=0 : OUT_NDIV=CLK2DSM=VCO/4/(ndiv-1) ; CLK2CNT static-high ; TESTCLK low
// NON-netlist assumption: M = ndiv[7:0]-1 (user spec) -> localparam.
//
// OUT_NDIV = clk_to_PFD = DFF_out.Q reclocked on NDIVCKIN(=VCO/4). pwsel (d_ndiv_pw_sel)
// selects WHICH counter state fires the EOC that drops clk_to_PFD = positions the falling
// edge. Validated duty law (sim, 2026-06-26):
//     low(NDIVCKIN) = pwsel-3 ; high = (ndiv-1)-(pwsel-3) ; duty = (ndiv+2-pwsel)/(ndiv-1)
//     => 50% duty  <=>  pwsel = (ndiv+5)/2   AND   ndiv % 4 == 3   (pwsel bit0 is unused, so
//        low quantizes ODD -> exact 50% only when (ndiv-1)/2 is an odd integer).
// So NDIV_TEST must be == 3 (mod 4) for the 50% duty check below to be exact. CLK2DSM
// (=SDMOUT) rises a FIXED 8.5 VCO = 2.125 NDIVCKIN cycles AFTER OUT_NDIV (structural,
// ndiv-independent). The CAL/TEST front-end taps (VCO/4, VCO/16) do NOT touch the mmd.
// -----------------------------------------------------------------------------

// measurement slots: rising-edge count + running-average period + high-time (for duty)
//   0 = OUT_NDIV   1 = CLK2DSM   2 = CLK2CNT   3 = TESTCLK_300M
`define RST(i) lr[i] = -1.0; ps[i] = 0.0; pn[i] = 0; ed[i] = 0; hr[i] = -1.0; hs[i] = 0.0; hn[i] = 0;

`define CKR(label, i, gold) \
  avgp  = (pn[i] > 0) ? (ps[i] / pn[i]) : 0.0; \
  ratio = (avgp > 0.0) ? (avgp / TVCO) : 0.0; \
  if (pn[i] == 0) begin $display("  FAIL %0s: no edges (expected VCO/%0d)", label, gold); fails = fails + 1; end \
  else if ((ratio > ((gold) + TOL)) || (ratio < ((gold) - TOL))) begin \
    $display("  FAIL %0s: measured VCO/%0.2f, expected VCO/%0d", label, ratio, gold); fails = fails + 1; end \
  else $display("  PASS %0s: VCO/%0d (measured VCO/%0.2f)", label, gold, ratio);

`define CKQ(label, i) \
  if (ed[i] > 0) begin $display("  FAIL %0s: expected quiet, saw %0d edges", label, ed[i]); fails = fails + 1; end \
  else $display("  PASS %0s: quiet", label);

// duty check: 100*avg_high/avg_period vs goldpct, tolerance DTOL (percent points)
`define CKD(label, i, goldpct) \
  duty = (hn[i] > 0 && pn[i] > 0) ? (100.0 * (hs[i]/hn[i]) / (ps[i]/pn[i])) : -1.0; \
  if (duty < 0.0) begin $display("  FAIL %0s duty: no edges", label); fails = fails + 1; end \
  else if ((duty > ((goldpct)+DTOL)) || (duty < ((goldpct)-DTOL))) begin \
    $display("  FAIL %0s duty = %0.1f%% (expected %0d%% +/-%0.0f)", label, duty, goldpct, DTOL); fails = fails + 1; end \
  else $display("  PASS %0s duty = %0.1f%% (expected %0d%%)", label, duty, goldpct);

module tb_LPBT_NDIV_TOP;
  // ---- slot indices ---------------------------------------------------------
  localparam integer I_OUT = 0, I_DSM = 1, I_CNT = 2, I_TST = 3;

  // ---- knobs ----------------------------------------------------------------
  // VCO = 4.8 GHz.  NDIVCKIN=CLK2CNT=VCO/4=1.2 GHz ; TESTCLK_300M=VCO/16=300 MHz ;
  // OUT_NDIV=CLK2DSM=VCO/4/(ndiv-1).  ndiv=51 -> D=200 -> 4.8 GHz/200 = 24 MHz.
  localparam real    TVCO      = 1000.0 / 4.8;        // VCO period [ps] -> 4.8 GHz input clock
  localparam integer NDIV_TEST = 51;                  // ndiv; D=4*(ndiv-1)=200 -> 24 MHz out
                                                       // 51 == 3 (mod 4) -> exact 50% duty achievable
  localparam integer M_GOLD    = NDIV_TEST - 1;       // MMD divisor    = ndiv-1  (user spec)
  localparam integer D_GOLD    = 4 * (NDIV_TEST - 1); // total = VCO / 4 / (ndiv-1) (netlist /4)
  localparam integer PWSEL     = (NDIV_TEST + 5) / 2; // duty law: pwsel=(ndiv+5)/2 -> 50% = (51+5)/2 = 28
  localparam real    TOL       = 0.05;                // divide-ratio tolerance
  localparam real    DTOL      = 3.0;                 // duty tolerance [percent points]
  localparam real    SETTLE    = 4.0  * D_GOLD * TVCO; // settle >= a few output periods
  localparam real    WIN       = 30.0 * D_GOLD * TVCO; // measure over ~30 output periods

  // ---- DUT I/O --------------------------------------------------------------
  reg         fromVCO;
  reg  [13:0] ndiv;
  reg  [5:0]  pwsel;
  reg         ndiv_en, cal_en, en_test, lpbt_en;
  wire        OUT_NDIV, CLK2DSM, CLK2CNT, TESTCLK_300M;
  reg         VDD, VPP, VSS, VDD_VCO, VPP_VCO, VSS_VCO, psub;

  integer fails;
  real    avgp, ratio, duty;

  // ---- measurement state ----------------------------------------------------
  real    lr [0:3];      // last rising-edge time
  real    ps [0:3];      // accumulated period
  integer pn [0:3];      // period samples
  integer ed [0:3];      // rising-edge count
  real    hr [0:3];      // last rising-edge time (for high-time / duty)
  real    hs [0:3];      // accumulated HIGH time
  integer hn [0:3];      // high-time samples

  LPBT_NDIV_TOP dut (
    .fromVCO(fromVCO), .ndiv(ndiv), .pwsel(pwsel),
    .ndiv_en(ndiv_en), .cal_en(cal_en), .en_test(en_test), .lpbt_en(lpbt_en),
    .OUT_NDIV(OUT_NDIV), .CLK2DSM(CLK2DSM), .CLK2CNT(CLK2CNT), .TESTCLK_300M(TESTCLK_300M),
    .VDD(VDD), .VPP(VPP), .VSS(VSS),
    .VDD_VCO(VDD_VCO), .VPP_VCO(VPP_VCO), .VSS_VCO(VSS_VCO), .psub(psub)
  );

  // ---- VCO clock ------------------------------------------------------------
  initial fromVCO = 1'b0;
  always #(TVCO/2.0) fromVCO = ~fromVCO;

  // ---- edge measurement (period via posedge, high-time via posedge->negedge) ----
  always @(posedge OUT_NDIV) begin
    ed[I_OUT] = ed[I_OUT] + 1;
    if (lr[I_OUT] >= 0.0) begin ps[I_OUT] = ps[I_OUT] + ($realtime - lr[I_OUT]); pn[I_OUT] = pn[I_OUT] + 1; end
    lr[I_OUT] = $realtime;  hr[I_OUT] = $realtime;
  end
  always @(negedge OUT_NDIV)
    if (hr[I_OUT] >= 0.0) begin hs[I_OUT] = hs[I_OUT] + ($realtime - hr[I_OUT]); hn[I_OUT] = hn[I_OUT] + 1; end
  always @(posedge CLK2DSM) begin
    ed[I_DSM] = ed[I_DSM] + 1;
    if (lr[I_DSM] >= 0.0) begin ps[I_DSM] = ps[I_DSM] + ($realtime - lr[I_DSM]); pn[I_DSM] = pn[I_DSM] + 1; end
    lr[I_DSM] = $realtime;  hr[I_DSM] = $realtime;
  end
  always @(negedge CLK2DSM)
    if (hr[I_DSM] >= 0.0) begin hs[I_DSM] = hs[I_DSM] + ($realtime - hr[I_DSM]); hn[I_DSM] = hn[I_DSM] + 1; end
  always @(posedge CLK2CNT) begin
    ed[I_CNT] = ed[I_CNT] + 1;
    if (lr[I_CNT] >= 0.0) begin ps[I_CNT] = ps[I_CNT] + ($realtime - lr[I_CNT]); pn[I_CNT] = pn[I_CNT] + 1; end
    lr[I_CNT] = $realtime;
  end
  always @(posedge TESTCLK_300M) begin
    ed[I_TST] = ed[I_TST] + 1;
    if (lr[I_TST] >= 0.0) begin ps[I_TST] = ps[I_TST] + ($realtime - lr[I_TST]); pn[I_TST] = pn[I_TST] + 1; end
    lr[I_TST] = $realtime;
  end

  // ---- stimulus / checks ----------------------------------------------------
  initial begin
    fails   = 0;
    ndiv    = NDIV_TEST;          // ndiv[13:8] are NC -> upper bits don't matter
    pwsel   = PWSEL;              // = (ndiv+5)/2 -> 50% duty on OUT_NDIV (see header)
    ndiv_en = 1'b0; cal_en = 1'b0; en_test = 1'b0; lpbt_en = 1'b0;   // lpbt_en NC
    {VDD,VPP,VDD_VCO,VPP_VCO} = 4'b1111;
    {VSS,VSS_VCO,psub}        = 3'b000;
    #(20*TVCO);

    // ===================== MODE: CAL (cal_en=1) =====================
    cal_en = 1'b1; ndiv_en = 1'b1; en_test = 1'b0;
    #(SETTLE);
    `RST(I_CNT) `RST(I_OUT) `RST(I_TST) `RST(I_DSM)
    #(WIN);
    $display("== CAL  (cal_en=1, ndiv_en=1) ==");
    `CKR("CLK2CNT = VCO/4", I_CNT, 4)         // CONFIRMED netlist: nand(DIV4sig,cal_en), front-end tap
    `CKQ("OUT_NDIV disabled", I_OUT)          // CONFIRMED netlist: NDIVCKIN frozen by nor(DIV4sig,cal_en)
    `CKQ("CLK2DSM quiet (mmd frozen)", I_DSM) // CONFIRMED netlist
    `CKQ("TESTCLK quiet (en_test=0)", I_TST)  // CONFIRMED netlist: pdown on enb_test

    // ===================== MODE: TEST (en_test=1) =====================
    cal_en = 1'b0; ndiv_en = 1'b1; en_test = 1'b1;
    #(SETTLE);
    `RST(I_CNT) `RST(I_OUT) `RST(I_TST) `RST(I_DSM)
    #(WIN);
    $display("== TEST (ndiv_en=1,cal_en=0,en_test=1) ==");
    `CKR("TESTCLK_300M = VCO/16", I_TST, 16)  // CONFIRMED netlist: DIV4sig->div4_tspc, front-end tap
    `CKQ("CLK2CNT static (cal_en=0)", I_CNT)  // CONFIRMED netlist: nand(DIV4sig,0)=1
    `CKR("OUT_NDIV = VCO/4/(ndiv-1)", I_OUT, D_GOLD)
    `CKR("CLK2DSM = VCO/4/(ndiv-1)",  I_DSM, D_GOLD)

    // ===================== MODE: NORMAL divide =====================
    cal_en = 1'b0; ndiv_en = 1'b1; en_test = 1'b0;
    #(SETTLE);
    `RST(I_CNT) `RST(I_OUT) `RST(I_TST) `RST(I_DSM)
    #(WIN);
    $display("== NORM (ndiv_en=1,cal_en=0) : ndiv=%0d pwsel=%0d -> D=4*(ndiv-1)=%0d ==", NDIV_TEST, PWSEL, D_GOLD);
    $display("  FREQ VCO = %0.3f GHz -> OUT_NDIV = %0.3f MHz (divide /%0d)",
             1000.0/TVCO, 1.0e6/(D_GOLD*TVCO), D_GOLD);
    `CKQ("CLK2CNT static (cal_en=0)", I_CNT)  // CONFIRMED netlist
    `CKQ("TESTCLK low (en_test=0)",   I_TST)  // CONFIRMED netlist
    `CKR("OUT_NDIV = VCO/4/(ndiv-1)", I_OUT, D_GOLD)
    `CKR("CLK2DSM = VCO/4/(ndiv-1)",  I_DSM, D_GOLD)
    // OUT_NDIV duty: hard 50% check when ndiv%4==3 (exact), else informational
    if ((NDIV_TEST % 4) == 3) begin
      `CKD("OUT_NDIV", I_OUT, 50)
    end else begin
      duty = (hn[I_OUT]>0 && pn[I_OUT]>0) ? (100.0*(hs[I_OUT]/hn[I_OUT])/(ps[I_OUT]/pn[I_OUT])) : 0.0;
      $display("  INFO OUT_NDIV duty = %0.1f%% (exact 50%% only when ndiv%%4==3 with pwsel=(ndiv+5)/2)", duty);
    end
    duty = (hn[I_DSM]>0 && pn[I_DSM]>0) ? (100.0*(hs[I_DSM]/hn[I_DSM])/(ps[I_DSM]/pn[I_DSM])) : 0.0;
    $display("  INFO CLK2DSM(SDMOUT) duty = %0.1f%% ; SDMOUT.pe lags OUT_NDIV.pe by 8.5 VCO (fixed)", duty);

    // ---- verdict ----
    if (fails == 0) $display("=== TB PASS ===");
    else            $display("=== TB FAIL (%0d) ===", fails);
    $finish;
  end

  // ---- waveform dump (opt-in: +define+WAVES) --------------------------------
  // Cadence SimVision SHM. needs xrun -access +rwc (run.sh adds it when WAVES set).
  // view with:  simvision ndiv.shm   (or  xrun ... -gui  for live)
`ifdef WAVES
  initial begin
    $shm_open("ndiv.shm");
    $shm_probe("AS");        // A=all signals, S=this scope + everything below
  end
`endif

  // safety timeout
  initial begin
    #(50_000_000);
    $display("=== TB FAIL (timeout) ===");
    $finish;
  end
endmodule
