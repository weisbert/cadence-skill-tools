`include "disciplines.vams"
`timescale 1ps/1fs
// =============================================================================
// tb_NDIV_TOP_v7_svt_0p5W.vams -- self-checking testbench for the WuR NDIV top
// (NDIV_TOP_v7_svt_0p5W). Drop-in for the auto-generated sim/run.sh (module is
// `tb`, run.sh uses -top tb). Method = "period-ratio": drive fromVCO as a square
// clock, set the divide word + control bits, and per MODE measure
// period(out)/period(fromVCO), assert the expected divide ratio, assert quiet
// outputs, assert OUT_NDIV duty, and X-guard the active clocks.
//
// LAWS -- GROUND-TRUTHED on the real Stage-A struct (local xcelium 18.03, 2026-06-27):
//
//   Front-end prescaler:  fromVCO -div2(I7)- -div2(I9)- DIV4sig = VCO/4.
//   lpbt_en is the PRESCALER SELECT for the 14-bit NDIV counter clock NDIVCKIN:
//       lpbt_en=1  (LPBT mode): NDIVCKIN = DIV4sig          = VCO/4
//       lpbt_en=0  (WuR  mode): NDIVCKIN = DIV4sig/4(DIV16) = VCO/16
//     (mux_sel = lpbt_en & ~cal_en ; div4_en = ~lpbt_en | en_test feeds the /16 + ADCDIV)
//
//   DIVIDE LAW (both modes, confirmed M = 10..300):
//       OUT_NDIV = CLK2DSM = NDIVCKIN / (ndiv-1)          -> M = ndiv-1
//       => WuR : OUT_NDIV = VCO / (16*(ndiv-1))
//          LPBT: OUT_NDIV = VCO / ( 4*(ndiv-1))
//     CLK2DSM tracks OUT_NDIV (same period), lagging ~2.07 NDIVCKIN cycles (structural).
//
//   pwsel -> PULSE-WIDTH LAW (counting unit = NDIVCKIN; confirmed by sweep, identical
//   in FORM to LPBT -- only the counting unit changed from VCO/4 to VCO/16):
//       low(NDIVCKIN) = 2*floor(pwsel/2) - 3      (pwsel[0] = don't-care)
//       period        = M = ndiv-1                (pwsel only moves the falling edge)
//       high          = M - low ;  duty = high/M
//       50% duty  <=>  pwsel = M/2 + 3 = (ndiv+5)/2,  EXACT only when M%4==2 (ndiv%4==3)
//       min usable pwsel = 4 (low=1); pwsel<=3 -> low<=-1 -> OUT_NDIV stalls (no edges)
//     Operating point here: ndiv=51 (51%4==3 -> exact 50%), pwsel=(51+5)/2=28.
//
//   CLK2CNT      = ~(DIV4sig & cal_en): VCO/4 only when cal_en=1, else static-high
//                  (pdown pulls it low when ndiv_en=0).
//   TESTCLK_300M = DIV16sig & en_test : VCO/16 when en_test=1 (=300MHz @ VCO=4.8G),
//                  else pdown-low.
//
//   OUT_ADCDIV (8-bit ADCDIV counter, clk = ADCDIVCKIN = VCO/4 when lpbt_en=0):
//       OUT_ADCDIV = VCO / (4*(adcdiv-1))                  -> M_adc = adcdiv-1
//     pwsel law = SAME step-2 form as NDIV but with a BIG +62 OFFSET. The 8-bit
//     EOC_low_short gate is nor3(nand12,d_low, nand(q6,q7b)) -> EOC_low (the falling-edge
//     trigger) fires only once the count reaches q6=1 (>=64), q7=0 -- opposite to the
//     14-bit, whose EOC needs the high bits =0. Hence:
//       low(ADCDIVCKIN) = 2*floor(adcpwsel/2) + 62         (adcpwsel[0] don't-care)
//       period = M_adc ;  high = M_adc - low
//       toggles ONLY when M_adc > low  <=>  adcdiv >= 2*floor(adcpwsel/2) + 64  (min ~64);
//         below that q6 never sets, EOC_low never fires, clk_to_PFD latches high (NO clock).
//       50% duty <=> adcpwsel = (adcdiv-1)/2 - 62.
//     Operating point here: adcdiv=165, adcpwsel=20 -> M=164, low=82 -> EXACT 50%,
//     OUT_ADCDIV = VCO/656. (A too-small adcdiv or too-large adcpwsel => low>=M => no
//     output: a PROGRAMMING constraint, NOT a model bug.)
// =============================================================================

// slots: 0=OUT_NDIV 1=CLK2DSM 2=CLK2CNT 3=TESTCLK_300M 4=OUT_ADCDIV
`define RST(i) lr[i]=-1.0; ps[i]=0.0; pn[i]=0; ed[i]=0; hr[i]=-1.0; hs[i]=0.0; hn[i]=0; xc[i]=0;

`define CKR(label, i, gold) \
  avgp  = (pn[i] > 0) ? (ps[i] / pn[i]) : 0.0; \
  ratio = (avgp > 0.0) ? (avgp / TVCO) : 0.0; \
  if (pn[i] == 0) begin $display("  FAIL %0s: no edges (expected VCO/%0d)", label, gold); fails=fails+1; end \
  else if ((ratio > ((gold)+TOL)) || (ratio < ((gold)-TOL))) begin \
    $display("  FAIL %0s: measured VCO/%0.2f, expected VCO/%0d", label, ratio, gold); fails=fails+1; end \
  else $display("  PASS %0s: VCO/%0d (measured VCO/%0.2f)", label, gold, ratio);

`define CKQ(label, i) \
  if (ed[i] > 0) begin $display("  FAIL %0s: expected quiet, saw %0d edges", label, ed[i]); fails=fails+1; end \
  else $display("  PASS %0s: quiet", label);

`define CKD(label, i, goldpct) \
  duty = (hn[i] > 0 && pn[i] > 0) ? (100.0*(hs[i]/hn[i])/(ps[i]/pn[i])) : -1.0; \
  if (duty < 0.0) begin $display("  FAIL %0s duty: no edges", label); fails=fails+1; end \
  else if ((duty > ((goldpct)+DTOL)) || (duty < ((goldpct)-DTOL))) begin \
    $display("  FAIL %0s duty = %0.1f%% (expected %0d%% +/-%0.0f)", label, duty, goldpct, DTOL); fails=fails+1; end \
  else $display("  PASS %0s duty = %0.1f%% (expected %0d%%)", label, duty, goldpct);

// X-guard: every rising edge of an active clock must land on a clean logic 1.
`define CKX(label, i) \
  if (xc[i] > 0) begin $display("  FAIL %0s: %0d active edge(s) not clean-1 (X/Z/0)", label, xc[i]); fails=fails+1; end \
  else if (ed[i] > 0) $display("  PASS %0s: clean (no X on active edges)", label);

// CKLO: assert a signal is sitting at a clean logic 0 right now (catches stuck-X/Z/1 that
// CKQ's edge-count can miss -- 0->x is not a posedge, so a constant-X reads "quiet").
`define CKLO(label, sig) \
  if ((sig) !== 1'b0) begin $display("  FAIL %0s: not clamped to clean 0 (level = %b)", label, sig); fails=fails+1; end \
  else $display("  PASS %0s: clamped to 0", label);

// VCO frequency knob (GHz).  Default 4.8 == the historical hard-coded value, so an
// invocation without the macro is unchanged; the 5.0 / 5.8 / 7.0 GHz runs are now
//    bash run.sh +define+FGHZ=7.0
// instead of a sed on the TVCO line.
`ifndef FGHZ
 `define FGHZ 4.8
`endif

module tb;
  localparam integer I_OUT=0, I_DSM=1, I_CNT=2, I_TST=3, I_ADC=4;

  // ---- knobs ----
  localparam real    FVCO_GHZ = `FGHZ;              // +define+FGHZ=<x>, default 4.8
  localparam real    TVCO    = 1000.0 / FVCO_GHZ;   // VCO period [ps] -> 4.8 GHz
  localparam integer NDIV    = 51;                  // 51 % 4 == 3 -> exact 50% achievable
  localparam integer M_GOLD  = NDIV - 1;            // counter divisor      = 50
  localparam integer PWSEL   = (NDIV + 5) / 2;      // 50% duty law         = 28
  localparam integer D_WUR   = 16 * (NDIV - 1);     // WuR  OUT_NDIV divide = 800 (VCO/800=6MHz)
  localparam integer D_LPBT  =  4 * (NDIV - 1);     // LPBT OUT_NDIV divide = 200 (VCO/200=24MHz)
  localparam integer ADCDIV  = 165;                 // M_adc=164; needs adcdiv >= adcpwsel+64
  localparam integer ADCPW   = 20;                  // (adcdiv-1)/2-62 = 20 -> exact 50% (low=82)
  localparam integer D_ADC   = 4 * (ADCDIV - 1);    // OUT_ADCDIV divide = 656 (VCO/656)
  localparam real    TOL     = 0.25;                // divide-ratio tolerance (abs, on the ratio)
  localparam real    DTOL    = 3.0;                 // duty tolerance [percent points]
  localparam real    SETTLE  = 6.0  * D_WUR * TVCO; // settle a few WuR output periods
  localparam real    WIN     = 40.0 * D_WUR * TVCO; // measure window

  // ---- DUT I/O ----
  reg         fromVCO;
  reg  [13:0] ndiv;
  reg  [7:0]  adcdiv;
  reg  [5:0]  pwsel, adcpwsel;
  reg         ndiv_en, cal_en, en_test, lpbt_en, psub;
  wire        OUT_NDIV, CLK2DSM, CLK2CNT, OUT_ADCDIV, TESTCLK_300M;
  reg         VDD, VPP, VSS, VDD_VCO, VPP_VCO, VSS_VCO;

  integer fails;
  real    avgp, ratio, duty;
  real    twin;          // start-of-window timestamp, for the report tool's per-mode zoom

// emit a machine-parseable per-mode measurement window [twin .. now] in ps (report tool reads it)
`define MARK(key) $display("MODEWIN %0s %0.1f %0.1f", key, twin, $realtime);

  // ---- measurement state (period / high-time / X) ----
  real    lr [0:4];   real ps [0:4];   integer pn [0:4];   integer ed [0:4];
  real    hr [0:4];   real hs [0:4];   integer hn [0:4];   integer xc [0:4];

  NDIV_TOP_v7_svt_0p5W dut (
    .CLK2CNT(CLK2CNT), .CLK2DSM(CLK2DSM), .OUT_ADCDIV(OUT_ADCDIV), .OUT_NDIV(OUT_NDIV),
    .TESTCLK_300M(TESTCLK_300M),
    .VDD(VDD), .VDD_VCO(VDD_VCO), .VPP(VPP), .VPP_VCO(VPP_VCO), .VSS(VSS), .VSS_VCO(VSS_VCO),
    .adcdiv(adcdiv), .adcpwsel(adcpwsel), .cal_en(cal_en), .en_test(en_test),
    .fromVCO(fromVCO), .lpbt_en(lpbt_en), .ndiv(ndiv), .ndiv_en(ndiv_en),
    .psub(psub), .pwsel(pwsel));

  // ---- VCO clock ----
  initial fromVCO = 1'b0;
  always #(TVCO/2.0) fromVCO = ~fromVCO;

  // ---- edge meters (period via posedge, high-time via posedge->negedge, X on posedge) ----
  always @(posedge OUT_NDIV) begin
    ed[I_OUT]=ed[I_OUT]+1; if (OUT_NDIV!==1'b1) xc[I_OUT]=xc[I_OUT]+1;
    if (lr[I_OUT]>=0.0) begin ps[I_OUT]=ps[I_OUT]+($realtime-lr[I_OUT]); pn[I_OUT]=pn[I_OUT]+1; end
    lr[I_OUT]=$realtime; hr[I_OUT]=$realtime;
  end
  always @(negedge OUT_NDIV)
    if (hr[I_OUT]>=0.0) begin hs[I_OUT]=hs[I_OUT]+($realtime-hr[I_OUT]); hn[I_OUT]=hn[I_OUT]+1; end
  always @(posedge CLK2DSM) begin
    ed[I_DSM]=ed[I_DSM]+1; if (CLK2DSM!==1'b1) xc[I_DSM]=xc[I_DSM]+1;
    if (lr[I_DSM]>=0.0) begin ps[I_DSM]=ps[I_DSM]+($realtime-lr[I_DSM]); pn[I_DSM]=pn[I_DSM]+1; end
    lr[I_DSM]=$realtime; hr[I_DSM]=$realtime;
  end
  always @(negedge CLK2DSM)
    if (hr[I_DSM]>=0.0) begin hs[I_DSM]=hs[I_DSM]+($realtime-hr[I_DSM]); hn[I_DSM]=hn[I_DSM]+1; end
  always @(posedge CLK2CNT) begin
    ed[I_CNT]=ed[I_CNT]+1; if (CLK2CNT!==1'b1) xc[I_CNT]=xc[I_CNT]+1;
    if (lr[I_CNT]>=0.0) begin ps[I_CNT]=ps[I_CNT]+($realtime-lr[I_CNT]); pn[I_CNT]=pn[I_CNT]+1; end
    lr[I_CNT]=$realtime;
  end
  always @(posedge TESTCLK_300M) begin
    ed[I_TST]=ed[I_TST]+1; if (TESTCLK_300M!==1'b1) xc[I_TST]=xc[I_TST]+1;
    if (lr[I_TST]>=0.0) begin ps[I_TST]=ps[I_TST]+($realtime-lr[I_TST]); pn[I_TST]=pn[I_TST]+1; end
    lr[I_TST]=$realtime;
  end
  always @(posedge OUT_ADCDIV) begin
    ed[I_ADC]=ed[I_ADC]+1; if (OUT_ADCDIV!==1'b1) xc[I_ADC]=xc[I_ADC]+1;
    if (lr[I_ADC]>=0.0) begin ps[I_ADC]=ps[I_ADC]+($realtime-lr[I_ADC]); pn[I_ADC]=pn[I_ADC]+1; end
    lr[I_ADC]=$realtime; hr[I_ADC]=$realtime;
  end
  always @(negedge OUT_ADCDIV)
    if (hr[I_ADC]>=0.0) begin hs[I_ADC]=hs[I_ADC]+($realtime-hr[I_ADC]); hn[I_ADC]=hn[I_ADC]+1; end

  initial begin
    fails   = 0;
    $display("RPTINFO fvco_ghz=%0.1f D_WUR=%0d D_LPBT=%0d D_ADC=%0d", FVCO_GHZ, D_WUR, D_LPBT, D_ADC);
    ndiv    = NDIV;  pwsel = PWSEL;  adcdiv = ADCDIV;  adcpwsel = ADCPW;
    ndiv_en = 1'b0;  cal_en = 1'b0;  en_test = 1'b0;  lpbt_en = 1'b0;  psub = 1'b0;
    {VDD,VPP,VDD_VCO,VPP_VCO} = 4'b1111;
    {VSS,VSS_VCO}             = 2'b00;
    #(20*TVCO);

    // ===================== MODE: WuR-NORMAL (lpbt_en=0) =====================
    ndiv_en = 1'b1; cal_en = 1'b0; en_test = 1'b0; lpbt_en = 1'b0;
    #(SETTLE);
    `RST(I_OUT) `RST(I_DSM) `RST(I_CNT) `RST(I_TST) `RST(I_ADC)
    twin = $realtime;
    #(WIN);
    $display("== WuR-NORMAL (lpbt_en=0) : ndiv=%0d pwsel=%0d -> OUT_NDIV=VCO/%0d (=%0.2f MHz) ==",
             NDIV, PWSEL, D_WUR, 1.0e6/(D_WUR*TVCO));
    `CKR("OUT_NDIV = VCO/16/(ndiv-1)", I_OUT, D_WUR)
    `CKR("CLK2DSM  = VCO/16/(ndiv-1)", I_DSM, D_WUR)
    `CKX("OUT_NDIV", I_OUT)
    `CKX("CLK2DSM",  I_DSM)
    `CKQ("CLK2CNT static (cal_en=0)", I_CNT)
    `CKQ("TESTCLK low (en_test=0)",   I_TST)
    if ((NDIV % 4) == 3) begin `CKD("OUT_NDIV", I_OUT, 50) end
    else $display("  INFO OUT_NDIV duty (exact 50%% only when ndiv%%4==3)");
    // OUT_ADCDIV: hard checks (adcdiv=165,adcpwsel=20 -> VCO/656, exact 50%).
    `CKR("OUT_ADCDIV = VCO/4/(adcdiv-1)", I_ADC, D_ADC)
    `CKX("OUT_ADCDIV", I_ADC)
    `CKD("OUT_ADCDIV", I_ADC, 50)
    `MARK("NORM")

    // ===================== MODE: LPBT (lpbt_en=1) =====================
    lpbt_en = 1'b1; cal_en = 1'b0; en_test = 1'b0;
    #(6.0*D_LPBT*TVCO);
    `RST(I_OUT) `RST(I_DSM) `RST(I_CNT) `RST(I_TST) `RST(I_ADC)
    twin = $realtime;
    #(40.0*D_LPBT*TVCO);
    $display("== LPBT-mode (lpbt_en=1) : OUT_NDIV=VCO/%0d (=%0.2f MHz) ==", D_LPBT, 1.0e6/(D_LPBT*TVCO));
    `CKR("OUT_NDIV = VCO/4/(ndiv-1)", I_OUT, D_LPBT)
    `CKR("CLK2DSM  = VCO/4/(ndiv-1)", I_DSM, D_LPBT)
    `CKX("OUT_NDIV", I_OUT)
    `CKQ("OUT_ADCDIV frozen (div4_en=0)", I_ADC)
    `MARK("LPBT")

    // ===================== MODE: CAL (cal_en=1) =====================
    lpbt_en = 1'b0; cal_en = 1'b1; en_test = 1'b0;
    #(SETTLE);
    `RST(I_OUT) `RST(I_DSM) `RST(I_CNT) `RST(I_TST) `RST(I_ADC)
    twin = $realtime;
    #(WIN);
    $display("== CAL (cal_en=1) : CLK2CNT monitor = VCO/4 ==");
    `CKR("CLK2CNT = VCO/4", I_CNT, 4)
    `CKX("CLK2CNT", I_CNT)
    `CKR("OUT_NDIV still = VCO/16/(ndiv-1)", I_OUT, D_WUR)   // cal_en does NOT freeze NDIV in WuR mode
    `MARK("CAL")

    // ===================== MODE: TEST (en_test=1) =====================
    lpbt_en = 1'b0; cal_en = 1'b0; en_test = 1'b1;
    #(SETTLE);
    `RST(I_OUT) `RST(I_DSM) `RST(I_CNT) `RST(I_TST) `RST(I_ADC)
    twin = $realtime;
    #(WIN);
    $display("== TEST (en_test=1) : TESTCLK_300M = VCO/16 ==");
    `CKR("TESTCLK_300M = VCO/16", I_TST, 16)
    `CKX("TESTCLK_300M", I_TST)
    `CKR("OUT_NDIV still = VCO/16/(ndiv-1)", I_OUT, D_WUR)
    `MARK("TEST")

    // ===================== MODE: POWER-DOWN (ndiv_en=0) =====================
    // power_en_b=1 -> the four pdown clamps (OUT_NDIV/CLK2DSM/CLK2CNT/OUT_ADCDIV) go ACTIVE->0
    // and net082(vdd_div)=0 unpowers the buffers; en_test=0 -> TESTCLK pdown ACTIVE->0.
    // Every chip output must settle to a CLEAN 0 -- no toggling AND no stuck-X (the pdown
    // tri-state-clamp bug class). CKLO catches a held-X that CKQ's edge-count would miss.
    ndiv_en = 1'b0; cal_en = 1'b0; en_test = 1'b0; lpbt_en = 1'b0;
    #(SETTLE);
    `RST(I_OUT) `RST(I_DSM) `RST(I_CNT) `RST(I_TST) `RST(I_ADC)
    twin = $realtime;
    #(8000*TVCO);
    $display("== POWER-DOWN (ndiv_en=0) : all chip outputs clamped to clean 0 ==");
    `CKQ("OUT_NDIV quiet",     I_OUT) `CKLO("OUT_NDIV",     OUT_NDIV)
    `CKQ("CLK2DSM quiet",      I_DSM) `CKLO("CLK2DSM",      CLK2DSM)
    `CKQ("CLK2CNT quiet",      I_CNT) `CKLO("CLK2CNT",      CLK2CNT)
    `CKQ("TESTCLK_300M quiet", I_TST) `CKLO("TESTCLK_300M", TESTCLK_300M)
    `CKQ("OUT_ADCDIV quiet",   I_ADC) `CKLO("OUT_ADCDIV",   OUT_ADCDIV)
    `MARK("PDN")

    // ---- verdict ----
    if (fails == 0) $display("=== TB PASS  (top=NDIV_TOP_v7_svt_0p5W) ===");
    else            $display("=== TB FAIL  (%0d mismatches) ===", fails);
    $finish;
  end

`ifdef WAVES
  initial begin $shm_open("ndiv.shm"); $shm_probe("AS"); end
`endif

  initial begin
    #(2_000_000_000);
    $display("=== TB FAIL (timeout) ===");
    $finish;
  end
endmodule
