`include "disciplines.vams"
`timescale 1s/1fs
// STRUCTURAL verilogams leaf: it is gathered as a "leaf" but itself instantiates
// further cells (subgain, subadd) -- mirrors the real pll_ndiv_delay_reload.
module delaycell (din, dout);
  input  din;
  output dout;
  wreal  din, dout;
  wreal  n1;
  subgain I0 ( .x(din), .y(n1) );
  subadd  I1 ( .a(n1), .b(din), .o(dout) );
endmodule
