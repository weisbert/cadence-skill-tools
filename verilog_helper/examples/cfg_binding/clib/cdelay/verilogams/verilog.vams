// Verilog-AMS netlist generated by the AMS netlister
// cdelay's verilogams is STRUCTURAL (a 2-inverter delay) -- it instantiates further
// in-design cells. The config binds cdelay :verilogams, so this IS the terminal the
// config chose (we must NOT descend cdelay's transistor schematic). Its sub-cells
// csub_a/csub_b get gathered recursively.
module cdelay ( a, en, z );
  input a, en;
  output z;
  wire mid;
  csub_a Ua ( .i(a), .o(mid) );
  csub_b Ub ( .i(mid), .o(z) );
endmodule
