// behavioral logic leaf (inverter)
module csub_a ( i, o );
  input i;
  output o;
  assign o = ~i;
endmodule
