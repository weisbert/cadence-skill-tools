`timescale 1ps/1ps
// =============================================================================
// mash111 -- behavioral, synthesizable-style 3rd-order MASH 1-1-1 sigma-delta
// modulator for the WuR PLL N-divider.
//
//   F        : W-bit fractional divide word, value F/2^W in [0,1)
//   y        : signed output, range [-3,+4], mean = F/2^W
//   clk      : the divider's SDM clock  -- on this chip that is CLK2DSM
//   rstn     : async reset (accumulators + differentiator delays)
//   en       : clock-enable
//   dither_en: add a 1-LSB LFSR dither into the first accumulator (breaks limit cycles)
//
// Three cascaded W-bit accumulators, combinationally chained inside one clock
// (stage n+1 accumulates the NEW residue of stage n), so the carries satisfy
//     C1 = F/2^W - (1-z^-1)E1 ,  C2 = E1 - (1-z^-1)E2 ,  C3 = E2 - (1-z^-1)E3
// and the error-cancellation network
//     y = C1 + (1-z^-1)C2 + (1-z^-1)^2 C3 = F/2^W - (1-z^-1)^3 E3
// leaves a pure 3rd-order-shaped quantization error (+60 dB/decade).
//
// The divider word is then  ndiv = N_int + y , average ndiv = N_int + F/2^W,
// so the average divide ratio is  M_avg = N_int - 1 + F/2^W  (law M = ndiv-1).
// =============================================================================
module mash111 #(parameter integer W = 20) (
  input  wire               clk,
  input  wire               rstn,
  input  wire               en,
  input  wire [W-1:0]       F,
  input  wire               dither_en,
  output reg  signed [3:0]  y
);
  reg [W-1:0] a1, a2, a3;      // accumulator states
  reg         c2d, c3d, c3dd;  // differentiator delay line
  reg [15:0]  lfsr;            // 1-LSB dither source

  wire        dbit = dither_en & lfsr[0];
  wire [W:0]  s1 = {1'b0, a1} + {1'b0, F} + dbit;
  wire [W:0]  s2 = {1'b0, a2} + {1'b0, s1[W-1:0]};
  wire [W:0]  s3 = {1'b0, a3} + {1'b0, s2[W-1:0]};

  always @(posedge clk or negedge rstn) begin
    if (!rstn) begin
      a1 <= {W{1'b0}}; a2 <= {W{1'b0}}; a3 <= {W{1'b0}};
      c2d <= 1'b0; c3d <= 1'b0; c3dd <= 1'b0;
      y <= 4'sd0;
      lfsr <= 16'hACE1;
    end else if (en) begin
      a1   <= s1[W-1:0];
      a2   <= s2[W-1:0];
      a3   <= s3[W-1:0];
      c2d  <= s2[W];
      c3d  <= s3[W];
      c3dd <= c3d;
      y    <= $signed({3'b000, s1[W]})
            + ($signed({3'b000, s2[W]}) - $signed({3'b000, c2d}))
            + ($signed({3'b000, s3[W]}) - 2*$signed({3'b000, c3d}) + $signed({3'b000, c3dd}));
      lfsr <= {lfsr[14:0], lfsr[15]^lfsr[13]^lfsr[12]^lfsr[10]};
    end
  end
endmodule
